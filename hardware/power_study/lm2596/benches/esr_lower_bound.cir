LM2596 fixed 5 V - esr_lower_bound - original TI and Vishay models
.include "../../vendor_model/LM2596_5P0_TRANS.LIB"
.include "../../vendor_model/ss36.lib"
VIN vin 0 PWL(0 0 100u 24)
VDIS disable 0 0
XU1 vin vout sw 0 disable LM2596_5P0_TRANS
CIN vin cinret 100u
RIN_ESR cinret 0 0.1
L1 sw lind 80u
RDCR lind vout 0.118
XD1 0 sw ss36
COUT vout esr 264u
RESR esr 0 0.056
VLOADCMD loadcmd 0 PWL(0 0.1 5m 0.1 5.01m 0.8 9m 0.8 9.01m 0.1)
GLOAD vout 0 VALUE={V(loadcmd)*LIMIT(V(vout)/4.75,0,1)}
.options method=gear maxord=2 reltol=0.003 abstol=1n vntol=1u
.tran 100n 12m 0 100n
.end
